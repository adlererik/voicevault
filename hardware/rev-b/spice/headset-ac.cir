VoiceVault B0 passive headphone path
* Codec output is an ideal AC source with assumed output resistance.
* This does not model codec distortion, protection, noise or headphone acoustics.
.param cval=220u esr=.015 rdriver=2 rseries=10 rload=32
Vcodec driver 0 DC .9 AC 1
Rdriver driver dc {rdriver}
Ccoupling dc cap {cval}
Resr cap series {esr}
Rlimit series headphone {rseries}
Rheadset headphone 0 {rload}
.control
ac dec 100 10 20000
let response = db(v(headphone))
meas ac gain_100 FIND response AT=100
meas ac gain_1000 FIND response AT=1000
meas ac gain_16000 FIND response AT=16000
wrdata headphone-ac.txt response
quit
.endc
.end
